| t27b.ibs * IBIS 3.2 Model
| 512Meg DDR SDRAM
| Part Number   VDD/VDDQ   Architecture   Package
| MT46V128M4TG   2.5V/2.5V   128 Meg x 4   66-pin TSOP
| MT46V64M8TG   2.5V/2.5V   64 Meg x 8   66-pin TSOP
| MT46V32M16TG   2.5V/2.5V   32 Meg x 16   66-pin TSOP
| MT46V128M4FN   2.5V/2.5V   128 Meg x 4   60-ball FBGA
| MT46V64M8FN   2.5V/2.5V   64 Meg x 8   60-ball FBGA
| MT46V32M16FN   2.5V/2.5V   32 Meg x 16   60-ball FBGA
[IBIS Ver]   3.2
[File name]   t27b.ibs
[File Rev]   2.3
[Date]   03/16/2005
[Source]   From silicon level SPICE model at Micron Technology, Inc.
   Micron Technology, Inc.
   8000 S. Federal Way
   P.O. Box 6, M/S: 01-711
   Boise, ID 83707-0006
[Notes]   Rev 1.0: 11/08/2002
   - Initial model, pre-silicon
   Rev 2.0 changes: 04/08/2003
   - models updated to match latest silicon measurements
   Rev 2.1 changes: 12/15/2003
   - models updated to match latest silicon measurements
   - added Vinl and Vinh corners to all models
   - added Vmeas corners to the dq model
   Rev 2.2 changes: 05/10/2004
   - TSOP package parasitics updated
   - C_comp values updated for all models
   - all models updated for 40C typical temperature
   Rev 2.3 changes: 03/16/2005
   - FBGA package typo fixed - "FJ" changed to "FN"
[Disclaimer]  This software code and all associated documentation, comments
              or other information (collectively "Software") is provided
              "AS IS" without warranty of any kind. MICRON TECHNOLOGY, INC.
              ("MTI") EXPRESSLY DISCLAIMS ALL WARRANTIES EXPRESS OR IMPLIED,
              INCLUDING BUT NOT LIMITED TO, NONINFRINGEMENT OF THIRD PARTY
              RIGHTS, AND ANY IMPLIED WARRANTIES OF MERCHANTABILITY OR
              FITNESS FOR ANY PARTICULAR PURPOSE. MTI DOES NOT WARRANT THAT
              THE SOFTWARE WILL MEET YOUR REQUIREMENTS, OR THAT THE
              OPERATION OF THE SOFTWARE WILL BE UNINTERRUPTED OR ERROR-FREE.
              FURTHERMORE, MTI DOES NOT MAKE ANY REPRESENTATIONS REGARDING
              THE USE OR THE RESULTS OF THE USE OF THE SOFTWARE IN TERMS OF
              ITS CORRECTNESS, ACCURACY, RELIABILITY, OR OTHERWISE. THE
              ENTIRE RISK ARISING OUT OF USE OR PERFORMANCE OF THE SOFTWARE
              REMAINS WITH YOU. IN NO EVENT SHALL MTI, ITS AFFILIATED
              COMPANIES OR THEIR SUPPLIERS BE LIABLE FOR ANY DIRECT,
              INDIRECT, CONSEQUENTIAL, INCIDENTAL, OR SPECIAL DAMAGES
              (INCLUDING, WITHOUT LIMITATION, DAMAGES FOR LOSS OF PROFITS,
              BUSINESS INTERRUPTION, OR LOSS OF INFORMATION) ARISING OUT OF
              YOUR USE OF OR INABILITY TO USE THE SOFTWARE, EVEN IF MTI HAS
              BEEN ADVISED OF THE POSSIBILITY OF SUCH DAMAGES. Because some
              jurisdictions prohibit the exclusion or limitation of
              liability for consequential or incidental damages, the above
              limitation may not apply to you.
[Copyright]   Copyright 2002 Micron Technology, Inc. All Rights Reserved.
|   COMPONENT: MT46V128M4TG
[Component]   MT46V128M4TG
[Manufacturer]  Micron Technology, Inc.
[Package]  | TSOP package
|   typ   min   max
R_pkg   70.4m   46.8m   77.2m
L_pkg   5.30nH   3.18nH   6.83nH
C_pkg   1.08pF   0.78pF   1.26pF
[Pin]   signal_name   model_name   R_pin   L_pin   C_pin
1   VDD   POWER   59.0m   5.69nH   2.85pF
2   NC   NC
3   VDDQ   POWER   77.6m   6.32nH   1.33pF
4   NC   NC
5   DQ0   DQ_FULL   75.0m   5.66nH   1.17pF
6   VSSQ   GND   75.6m   5.70nH   1.22pF
7   NC   NC
8   NC   NC
9   VDDQ   POWER   71.3m   4.97nH   1.11pF
10   NC   NC
11   DQ1   DQ_FULL   69.8m   4.80nH   1.05pF
12   VSSQ   GND   68.2m   4.74nH   0.99pF
13   NC   NC
14   NC   NC
15   VDDQ   POWER   63.7m   4.31nH   0.83pF
16   NC   NC
17   NC   NC
18   VDD   POWER   62.7m   4.32nH   0.77pF
19   DNU   NC
20   NC   NC
21   WE#   INPUT   46.8m   3.18nH   0.95pF
22   CAS#   INPUT   63.6m   4.37nH   0.98pF
23   RAS#   INPUT   64.2m   4.44nH   0.99pF
24   CS#   INPUT   66.1m   4.52nH   1.10pF
25   NC   NC
26   BA0   INPUT   67.7m   4.49nH   1.19pF
27   BA1   INPUT   67.8m   4.67nH   1.22pF
28   A10   INPUT   72.7m   5.41nH   1.17pF
29   A0   INPUT   74.9m   5.47nH   1.22pF
30   A1   INPUT   75.3m   5.79nH   1.26pF
31   A2   INPUT   75.7m   6.22nH   1.17pF
32   A3   INPUT   75.6m   6.46nH   1.16pF
33   VDD   POWER   59.0m   5.69nH   2.85pF
34   VSS   GND   59.0m   5.69nH   2.85pF
35   A4   INPUT   77.2m   6.67nH   1.25pF
36   A5   INPUT   76.2m   6.83nH   1.22pF
37   A6   INPUT   76.1m   6.80nH   1.16pF
38   A7   INPUT   77.2m   6.60nH   1.20pF
39   A8   INPUT   75.5m   6.39nH   1.17pF
40   A9   INPUT   75.7m   6.16nH   1.14pF
41   A11   INPUT   75.3m   5.81nH   1.10pF
42   A12   INPUT   74.5m   5.47nH   1.05pF
43   NC   NC
44   CKE   INPUT   72.4m   5.29nH   0.96pF
45   CK   INPUT   71.3m   5.07nH   0.94pF
46   CK#   INPUT   67.9m   4.36nH   0.92pF
47   DM   DM_INPUT   65.9m   4.42nH   0.87pF
48   VSS   GND   63.9m   4.40nH   0.87pF
49   VREF   POWER   62.7m   4.32nH   0.77pF
50   DNU   NC
51   DQS   DQ_FULL   59.4m   4.16nH   0.78pF
52   VSSQ   GND   60.5m   4.06nH   0.78pF
53   NC   NC
54   NC   NC   61.3m   4.05nH   0.87pF
55   VDDQ   POWER   62.9m   4.22nH   0.90pF
56   DQ2   DQ_FULL   66.5m   4.59nH   0.96pF
57   NC   NC
58   VSSQ   GND   69.3m   4.74nH   1.05pF
59   NC   NC
60   NC   NC
61   VDDQ   POWER   73.3m   5.19nH   1.14pF
62   DQ3   DQ_FULL   75.3m   5.52nH   1.17pF
63   NC   NC
64   VSSQ   GND   74.7m   5.69nH   1.16pF
65   NC   NC
66   VSS   GND   59.0m   5.69nH   2.85pF
|**********************DIFF PIN*********************************************
[Diff_pin]   inv_pin   vdiff   tdelay_typ   tdelay_min   tdelay_max
   45   46   .360V   0ns   NA   NA
|   COMPONENT: MT46V64M8TG
[Component]   MT46V64M8TG
[Manufacturer]  Micron Technology, Inc.
[Package]  | TSOP package
|   typ   min   max
R_pkg   71.0m   46.8m   77.2m
L_pkg   5.38nH   3.18nH   6.83nH
C_pkg   1.10pF   0.78pF   1.26pF
[Pin]   signal_name   model_name   R_pin   L_pin   C_pin
1   VDD   POWER   59.0m   5.69nH   2.85pF
2   DQ0   DQ_FULL   73.6m   6.58nH   1.26pF
3   VDDQ   POWER   77.6m   6.32nH   1.33pF
4   NC   NC
5   DQ1   DQ_FULL   75.0m   5.66nH   1.17pF
6   VSSQ   GND   75.6m   5.70nH   1.22pF
7   NC   NC
8   DQ2   DQ_FULL   73.1m   5.21nH   1.14pF
9   VDDQ   POWER   71.3m   4.97nH   1.11pF
10   NC   NC
11   DQ3   DQ_FULL   69.8m   4.80nH   1.05pF
12   VSSQ   GND   68.2m   4.74nH   0.99pF
13   NC   NC
14   NC   NC
15   VDDQ   POWER   63.7m   4.31nH   0.83pF
16   NC   NC
17   NC   NC
18   VDD   POWER   62.7m   4.32nH   0.77pF
19   DNU   NC
20   NC   NC
21   WE#   INPUT   46.8m   3.18nH   0.95pF
22   CAS#   INPUT   63.6m   4.37nH   0.98pF
23   RAS#   INPUT   64.2m   4.44nH   0.99pF
24   CS#   INPUT   66.1m   4.52nH   1.10pF
25   NC   NC
26   BA0   INPUT   67.7m   4.49nH   1.19pF
27   BA1   INPUT   67.8m   4.67nH   1.22pF
28   A10   INPUT   72.7m   5.41nH   1.17pF
29   A0   INPUT   74.9m   5.47nH   1.22pF
30   A1   INPUT   75.3m   5.79nH   1.26pF
31   A2   INPUT   75.7m   6.22nH   1.17pF
32   A3   INPUT   75.6m   6.46nH   1.16pF
33   VDD   POWER   59.0m   5.69nH   2.85pF
34   VSS   GND   59.0m   5.69nH   2.85pF
35   A4   INPUT   77.2m   6.67nH   1.25pF
36   A5   INPUT   76.2m   6.83nH   1.22pF
37   A6   INPUT   76.1m   6.80nH   1.16pF
38   A7   INPUT   77.2m   6.60nH   1.20pF
39   A8   INPUT   75.5m   6.39nH   1.17pF
40   A9   INPUT   75.7m   6.16nH   1.14pF
41   A11   INPUT   75.3m   5.81nH   1.10pF
42   A12   INPUT   74.5m   5.47nH   1.05pF
43   NC   NC
44   CKE   INPUT   72.4m   5.29nH   0.96pF
45   CK   INPUT   71.3m   5.07nH   0.94pF
46   CK#   INPUT   67.9m   4.36nH   0.92pF
47   DM   DM_INPUT   65.9m   4.42nH   0.87pF
48   VSS   GND   63.9m   4.40nH   0.87pF
49   VREF   POWER   62.7m   4.32nH   0.77pF
50   DNU   NC
51   DQS   DQ_FULL   59.4m   4.16nH   0.78pF
52   VSSQ   GND   60.5m   4.06nH   0.78pF
53   NC   NC
54   NC   NC
55   VDDQ   POWER   62.9m   4.22nH   0.90pF
56   DQ4   DQ_FULL   66.5m   4.59nH   0.96pF
57   NC   NC
58   VSSQ   GND   69.3m   4.74nH   1.05pF
59   DQ5   DQ_FULL   69.8m   4.75nH   1.08pF
60   NC   NC
61   VDDQ   POWER   73.3m   5.19nH   1.14pF
62   DQ6   DQ_FULL   75.3m   5.52nH   1.17pF
63   NC   NC
64   VSSQ   GND   74.7m   5.69nH   1.16pF
65   DQ7   DQ_FULL   74.7m   5.94nH   1.21pF
66   VSS   GND   59.0m   5.69nH   2.85pF
|**********************DIFF PIN*********************************************
[Diff_pin]   inv_pin   vdiff   tdelay_typ   tdelay_min   tdelay_max
   45   46   .360V   0ns   NA   NA
|   COMPONENT: MT46V32M16TG
[Component]   MT46V32M16TG
[Manufacturer]  Micron Technology, Inc.
[Package]  | TSOP package
|   typ   min   max
R_pkg   70.2m   46.8m   77.2m
L_pkg   5.23nH   3.12nH   6.83nH
C_pkg   1.08pF   0.78pF   1.26pF
[Pin]   signal_name   model_name   R_pin   L_pin   C_pin
1   VDD   POWER   59.0m   5.69nH   2.85pF
2   DQ0   DQ   73.6m   6.58nH   1.26pF
3   VDDQ   POWER   77.6m   6.32nH   1.33pF
4   DQ1   DQ   75.0m   5.98nH   1.21pF
5   DQ2   DQ   75.0m   5.66nH   1.17pF
6   VSSQ   GND   75.6m   5.70nH   1.22pF
7   DQ3   DQ   75.4m   5.59nH   1.17pF
8   DQ4   DQ   73.1m   5.21nH   1.14pF
9   VDDQ   POWER   71.3m   4.97nH   1.11pF
10   DQ5   DQ   70.2m   4.81nH   1.09pF
11   DQ6   DQ   69.8m   4.80nH   1.05pF
12   VSSQ   GND   68.2m   4.74nH   0.99pF
13   DQ7   DQ   67.0m   4.65nH   0.96pF
14   NC   NC
15   VDDQ   POWER   63.7m   4.31nH   0.83pF
16   LDQS   DQ   63.2m   3.98nH   0.80pF
17   NC   NC
18   VDD   POWER   62.7m   4.32nH   0.77pF
19   DNU   NC
20   LDM   DM_INPUT   50.2m   3.12nH   0.92pF
21   WE#   INPUT   46.8m   3.18nH   0.95pF
22   CAS#   INPUT   63.6m   4.37nH   0.98pF
23   RAS#   INPUT   64.2m   4.44nH   0.99pF
24   CS#   INPUT   66.1m   4.52nH   1.10pF
25   NC   NC
26   BA0   INPUT   67.7m   4.49nH   1.19pF
27   BA1   INPUT   67.8m   4.67nH   1.22pF
28   A10   INPUT   72.7m   5.41nH   1.17pF
29   A0   INPUT   74.9m   5.47nH   1.22pF
30   A1   INPUT   75.3m   5.79nH   1.26pF
31   A2   INPUT   75.7m   6.22nH   1.17pF
32   A3   INPUT   75.6m   6.46nH   1.16pF
33   VDD   POWER   59.0m   5.69nH   2.85pF
34   VSS   GND   59.0m   5.69nH   2.85pF
35   A4   INPUT   77.2m   6.67nH   1.25pF
36   A5   INPUT   76.2m   6.83nH   1.22pF
37   A6   INPUT   76.1m   6.80nH   1.16pF
38   A7   INPUT   77.2m   6.60nH   1.20pF
39   A8   INPUT   75.5m   6.39nH   1.17pF
40   A9   INPUT   75.7m   6.16nH   1.14pF
41   A11   INPUT   75.3m   5.81nH   1.10pF
42   A12   INPUT   74.5m   5.47nH   1.05pF
43   NC   NC
44   CKE   INPUT   72.4m   5.29nH   0.96pF
45   CK   INPUT   71.3m   5.07nH   0.94pF
46   CK#   INPUT   67.9m   4.36nH   0.92pF
47   UDM   DM_INPUT   65.9m   4.42nH   0.87pF
48   VSS   GND   63.9m   4.40nH   0.87pF
49   VREF   POWER   62.7m   4.32nH   0.77pF
50   DNU   NC
51   UDQS   DQ   59.4m   4.16nH   0.78pF
52   VSSQ   GND   60.5m   4.06nH   0.78pF
53   NC   NC
54   DQ8   DQ   61.3m   4.05nH   0.87pF
55   VDDQ   POWER   62.9m   4.22nH   0.90pF
56   DQ9   DQ   66.5m   4.59nH   0.96pF
57   DQ10   DQ   67.8m   4.70nH   0.99pF
58   VSSQ   GND   69.3m   4.74nH   1.05pF
59   DQ11   DQ   69.8m   4.75nH   1.08pF
60   DQ12   DQ   71.0m   4.94nH   1.10pF
61   VDDQ   POWER   73.3m   5.19nH   1.14pF
62   DQ13   DQ   75.3m   5.52nH   1.17pF
63   DQ14   DQ   75.6m   5.65nH   1.21pF
64   VSSQ   GND   74.7m   5.69nH   1.16pF
65   DQ15   DQ   74.7m   5.94nH   1.21pF
66   VSS   GND   59.0m   5.69nH   2.85pF
|**********************DIFF PIN*********************************************
[Diff_pin]   inv_pin   vdiff   tdelay_typ   tdelay_min   tdelay_max
   45   46   .360V   0ns   NA   NA
|   COMPONENT: MT46V128M4FN
[Component]   MT46V128M4FN
[Manufacturer]  Micron Technology, Inc.
[Package]  | FBGA package
|   typ   min   max
R_pkg   54.0m   44.8m   65.1m
L_pkg   1.68nH   1.24nH   2.43nH
C_pkg   0.53pF   0.46pF   0.67pF
[Pin]   signal_name   model_name   R_pin   L_pin   C_pin
A1   VSSQ   GND   66.3m   2.38nH   0.59pF
A2   NC   NC
A3   VSS   GND   54.9m   2.31nH   0.69pF
A7   VDD   POWER   51.8m   1.92nH   0.71pF
A8   NC   NC
A9   VDDQ   POWER   80.0m   2.97nH   0.65pF
B1   NC   NC
B2   VDDQ   POWER   68.1m   2.23nH   0.62pF
B3   DQ3   DQ_FULL   52.8m   1.55nH   0.63pF
B7   DQ0   DQ_FULL   52.0m   1.39nH   0.63pF
B8   VSSQ   GND   66.8m   2.30nH   0.58pF
B9   NC   NC
C1   NC   NC
C2   VSSQ   GND   66.6m   2.40nH   0.61pF
C3   NC   NC
C7   NC   NC
C8   VDDQ   POWER   65.3m   2.20nH   0.59pF
C9   NC   NC
D1   NC   NC
D2   VDDQ   POWER   65.6m   2.10nH   0.59pF
D3   DQ2   DQ_FULL   49.4m   1.36nH   0.61pF
D7   DQ1   DQ_FULL   50.1m   1.31nH   0.59pF
D8   VSSQ   GND   64.9m   2.19nH   0.57pF
D9   NC   NC
E1   NC   NC
E2   VSSQ   GND   78.7m   3.13nH   0.62pF
E3   DQS   DQ_FULL   51.8m   1.36nH   0.57pF
E7   NC   NC
E8   VDDQ   POWER   63.6m   1.96nH   0.57pF
E9   NC   NC
F1   VREF   POWER   77.3m   2.50nH   0.56pF
F2   VSS   GND   50.6m   1.56nH   0.53pF
F3   DM   DM_INPUT   59.6m   1.65nH   0.67pF
F7   NC   NC
F8   VDD   POWER   50.7m   1.55nH   0.50pF
F9   NC   NC
G2   CLK   INPUT   62.8m   2.19nH   0.53pF
G3   CLK#   INPUT   50.6m   1.49nH   0.59pF
G7   WE#   INPUT   48.2m   1.39nH   0.55pF
G8   CAS#   INPUT   59.5m   2.12nH   0.48pF
H2   A12   INPUT   59.4m   2.12nH   0.46pF
H3   CKE   INPUT   47.2m   1.36nH   0.48pF
H7   RAS#   INPUT   46.6m   1.36nH   0.47pF
H8   CS#   INPUT   57.9m   2.06nH   0.46pF
J2   A11   INPUT   59.9m   2.01nH   0.48pF
J3   A9   INPUT   45.6m   1.31nH   0.47pF
J7   BA1   INPUT   45.5m   1.30nH   0.46pF
J8   BA0   INPUT   59.0m   2.02nH   0.46pF
K2   A8   INPUT   59.6m   1.96nH   0.49pF
K3   A7   INPUT   44.8m   1.24nH   0.49pF
K7   A0   INPUT   46.1m   1.28nH   0.48pF
K8   A10   INPUT   57.2m   1.84nH   0.46pF
L2   A6   INPUT   59.8m   2.06nH   0.52pF
L3   A5   INPUT   48.6m   1.36nH   0.56pF
L7   A2   INPUT   48.6m   1.44nH   0.55pF
L8   A1   INPUT   59.4m   2.11nH   0.50pF
M2   A4   INPUT   65.1m   2.03nH   0.59pF
M3   VSS   GND   54.5m   1.79nH   0.51pF
M7   VDD   POWER   53.8m   1.76nH   0.54pF
M8   A3   INPUT   65.1m   2.43nH   0.56pF
|**********************DIFF PIN*********************************************
[Diff_pin]   inv_pin   vdiff   tdelay_typ   tdelay_min   tdelay_max
   G2   G3   .360V   0ns   NA   NA
|   COMPONENT: MT46V64M8FN
[Component]   MT46V64M8FN
[Manufacturer]  Micron Technology, Inc.
[Package]  | FBGA package
|   typ   min   max
R_pkg   54.6m   44.8m   66.1m
L_pkg   1.68nH   1.24nH   2.43nH
C_pkg   0.54pF   0.46pF   0.67pF
[Pin]   signal_name   model_name   R_pin   L_pin   C_pin
A1   VSSQ   GND   66.3m   2.38nH   0.59pF
A2   DQ7   DQ_FULL   65.3m   1.66nH   0.63pF
A3   VSS   GND   54.9m   2.31nH   0.69pF
A7   VDD   POWER   51.8m   1.92nH   0.71pF
A8   DQ0   DQ_FULL   66.1m   2.25nH   0.65pF
A9   VDDQ   POWER   80.0m   2.97nH   0.65pF
B1   NC   NC
B2   VDDQ   POWER   68.1m   2.23nH   0.62pF
B3   DQ6   DQ_FULL   52.8m   1.55nH   0.63pF
B7   DQ1   DQ_FULL   52.0m   1.39nH   0.63pF
B8   VSSQ   GND   66.8m   2.30nH   0.58pF
B9   NC   NC
C1   NC   NC
C2   VSSQ   GND   66.6m   2.40nH   0.61pF
C3   DQ5   DQ_FULL   51.3m   1.35nH   0.61pF
C7   DQ2   DQ_FULL   51.8m   1.51nH   0.61pF
C8   VDDQ   POWER   65.3m   2.20nH   0.59pF
C9   NC   NC
D1   NC   NC
D2   VDDQ   POWER   65.6m   2.10nH   0.59pF
D3   DQ4   DQ_FULL   49.4m   1.36nH   0.61pF
D7   DQ3   DQ_FULL   50.1m   1.31nH   0.59pF
D8   VSSQ   GND   64.9m   2.19nH   0.57pF
D9   NC   NC
E1   NC   NC
E2   VSSQ   GND   78.7m   3.13nH   0.62pF
E3   DQS   DQ_FULL   51.8m   1.36nH   0.57pF
E7   NC   NC
E8   VDDQ   POWER   63.6m   1.96nH   0.57pF
E9   NC   NC
F1   VREF   POWER   77.3m   2.50nH   0.56pF
F2   VSS   GND   50.6m   1.56nH   0.53pF
F3   DM   DM_INPUT   59.6m   1.65nH   0.67pF
F7   NC   NC
F8   VDD   POWER   50.7m   1.55nH   0.50pF
F9   NC   NC
G2   CLK   INPUT   62.8m   2.19nH   0.53pF
G3   CLK#   INPUT   50.6m   1.49nH   0.59pF
G7   WE#   INPUT   48.2m   1.39nH   0.55pF
G8   CAS#   INPUT   59.5m   2.12nH   0.48pF
H2   A12   INPUT   59.4m   2.12nH   0.46pF
H3   CKE   INPUT   47.2m   1.36nH   0.48pF
H7   RAS#   INPUT   46.6m   1.36nH   0.47pF
H8   CS#   INPUT   57.9m   2.06nH   0.46pF
J2   A11   INPUT   59.9m   2.01nH   0.48pF
J3   A9   INPUT   45.6m   1.31nH   0.47pF
J7   BA1   INPUT   45.5m   1.30nH   0.46pF
J8   BA0   INPUT   59.0m   2.02nH   0.46pF
K2   A8   INPUT   59.6m   1.96nH   0.49pF
K3   A7   INPUT   44.8m   1.24nH   0.49pF
K7   A0   INPUT   46.1m   1.28nH   0.48pF
K8   A10   INPUT   57.2m   1.84nH   0.46pF
L2   A6   INPUT   59.8m   2.06nH   0.52pF
L3   A5   INPUT   48.6m   1.36nH   0.56pF
L7   A2   INPUT   48.6m   1.44nH   0.55pF
L8   A1   INPUT   59.4m   2.11nH   0.50pF
M2   A4   INPUT   65.1m   2.03nH   0.59pF
M3   VSS   GND   54.5m   1.79nH   0.51pF
M7   VDD   POWER   53.8m   1.76nH   0.54pF
M8   A3   INPUT   65.1m   2.43nH   0.56pF
|**********************DIFF PIN*********************************************
[Diff_pin]   inv_pin   vdiff   tdelay_typ   tdelay_min   tdelay_max
   G2   G3   .360V   0ns   NA   NA
|   COMPONENT: MT46V32M16FN
[Component]   MT46V32M16FN
[Manufacturer]  Micron Technology, Inc.
[Package]  | FBGA package
|   typ   min   max
R_pkg   59.5m   44.8m   81.7m
L_pkg   1.87nH   1.24nH   2.92nH
C_pkg   0.55pF   0.46pF   0.67pF
[Pin]   signal_name   model_name   R_pin   L_pin   C_pin
A1   VSSQ   GND   66.3m   2.38nH   0.59pF
A2   DQ15   DQ   65.3m   1.66nH   0.63pF
A3   VSS   GND   54.9m   2.31nH   0.69pF
A7   VDD   POWER   51.8m   1.92nH   0.71pF
A8   DQ0   DQ   66.1m   2.25nH   0.65pF
A9   VDDQ   POWER   80.0m   2.97nH   0.65pF
B1   DQ14   DQ   80.7m   2.41nH   0.60pF
B2   VDDQ   POWER   68.1m   2.23nH   0.62pF
B3   DQ13   DQ   52.8m   1.55nH   0.63pF
B7   DQ2   DQ   52.0m   1.39nH   0.63pF
B8   VSSQ   GND   66.8m   2.30nH   0.58pF
B9   DQ1   DQ   81.7m   2.87nH   0.62pF
C1   DQ12   DQ   79.9m   2.86nH   0.58pF
C2   VSSQ   GND   66.6m   2.40nH   0.61pF
C3   DQ11   DQ   51.3m   1.35nH   0.61pF
C7   DQ4   DQ   51.8m   1.51nH   0.61pF
C8   VDDQ   POWER   65.3m   2.20nH   0.59pF
C9   DQ3   DQ   80.8m   2.67nH   0.60pF
D1   DQ10   DQ   79.3m   2.53nH   0.58pF
D2   VDDQ   POWER   65.6m   2.10nH   0.59pF
D3   DQ9   DQ   49.4m   1.36nH   0.61pF
D7   DQ6   DQ   50.1m   1.31nH   0.59pF
D8   VSSQ   GND   64.9m   2.19nH   0.57pF
D9   DQ5   DQ   80.9m   2.92nH   0.57pF
E1   DQ8   DQ   77.1m   2.36nH   0.55pF
E2   VSSQ   GND   78.7m   3.13nH   0.62pF
E3   UDQS   DQ   51.8m   1.36nH   0.57pF
E7   LDQS   DQ   51.2m   1.49nH   0.59pF
E8   VDDQ   POWER   63.6m   1.96nH   0.57pF
E9   DQ7   DQ   77.7m   2.50nH   0.55pF
F1   VREF   POWER   77.3m   2.50nH   0.56pF
F2   VSS   GND   50.6m   1.56nH   0.53pF
F3   UDM   DM_INPUT   59.6m   1.65nH   0.67pF
F7   LDM   DM_INPUT   61.2m   1.93nH   0.65pF
F8   VDD   POWER   50.7m   1.55nH   0.50pF
F9   NC   NC
G2   CLK   INPUT   62.8m   2.19nH   0.53pF
G3   CLK#   INPUT   50.6m   1.49nH   0.59pF
G7   WE#   INPUT   48.2m   1.39nH   0.55pF
G8   CAS#   INPUT   59.5m   2.12nH   0.48pF
H2   A12   INPUT   59.4m   2.12nH   0.46pF
H3   CKE   INPUT   47.2m   1.36nH   0.48pF
H7   RAS#   INPUT   46.6m   1.36nH   0.47pF
H8   CS#   INPUT   57.9m   2.06nH   0.46pF
J2   A11   INPUT   59.9m   2.01nH   0.48pF
J3   A9   INPUT   45.6m   1.31nH   0.47pF
J7   BA1   INPUT   45.5m   1.30nH   0.46pF
J8   BA0   INPUT   59.0m   2.02nH   0.46pF
K2   A8   INPUT   59.6m   1.96nH   0.49pF
K3   A7   INPUT   44.8m   1.24nH   0.49pF
K7   A0   INPUT   46.1m   1.28nH   0.48pF
K8   A10   INPUT   57.2m   1.84nH   0.46pF
L2   A6   INPUT   59.8m   2.06nH   0.52pF
L3   A5   INPUT   48.6m   1.36nH   0.56pF
L7   A2   INPUT   48.6m   1.44nH   0.55pF
L8   A1   INPUT   59.4m   2.11nH   0.50pF
M2   A4   INPUT   65.1m   2.03nH   0.59pF
M3   VSS   GND   54.5m   1.79nH   0.51pF
M7   VDD   POWER   53.8m   1.76nH   0.54pF
M8   A3   INPUT   65.1m   2.43nH   0.56pF
|**********************DIFF PIN*********************************************
[Diff_pin]   inv_pin   vdiff   tdelay_typ   tdelay_min   tdelay_max
   G2   G3   .360V   0ns   NA   NA
|***********************MODEL SELECTOR**************************************
[Model Selector] DQ
DQ_FULL   Full-Strength IO Driver
DQ_HALF   54% Reduced Drive Strength IO Driver
| Models and submodels in the file (4): DQ_FULL (I/O), DQ_HALF (I/O), INPUT (Input), DM_INPUT (Input)
